`include "constants.h"
`include "discipline.h"

module driver(input in, output out);
    electrical in, out;

    analog begin

        V(out) <+ V(in) * 3.3;

    end

endmodule
