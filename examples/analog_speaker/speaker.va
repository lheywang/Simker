`include "disciplines.h"
`include "constants.h"

module speaker(input p, input n, output x_mon);

    electrical p, n, x_mon;

    kinematic mech_node;
    thermal thermal_node;

    // =========================
    // 1. DATASHEET PARAMETERS
    // =========================
    parameter real Mms_g     = 33.0;
    parameter real Fs        = 34.0;
    parameter real Qms       = 2.82;
    parameter real Bl        = 3.8;
    parameter real Re        = 5.9;
    parameter real Le        = 0.8e-3;

    // Thermal
    parameter real Tamb      = 22.0; // Celsius
    parameter real R_th      = 2.0;
    parameter real C_th      = 10.0;
    parameter real Alpha_Cu  = 0.00393;

    // Non-linear stiffness (Soft Clipping)
    parameter real Kms_stiff_factor = 500;

    // =========================
    // 2. INTERNAL VARIABLES
    // =========================
    real M_si, R_si, K_si; // SI Unit versions
    real w0;

    real i_coil, v_coil;
    real x, v;
    real temp_val, Re_dynamic;
    real spring_force;

    // =========================
    // 3. INITIALIZATION (Calculate Once)
    // =========================
    analog initial begin
        // A. Unit Conversion (Grams -> Kg)
        M_si = Mms_g * 1e-3;

        // B. Calculate Mechanical Parameters from Fs/Qms
        w0   = 2.0 * `M_PI * Fs;

        // Stiffness K = M * w^2
        K_si = M_si * w0 * w0;

        // Damping R = (M * w) / Qms
        R_si = (M_si * w0) / Qms;

        // Debug print to verify standard values
        $strobe("Speaker Init: M=%.4f kg, K=%.2f N/m, R=%.4f", M_si, K_si, R_si);
    end

    // =========================
    // 4. RUNTIME BEHAVIOR
    // =========================
    analog begin
        // --- READ SENSORS ---
        i_coil   = I(p, n);
        x        = Pos(mech_node);
        v        = ddt(x);
        temp_val = Temp(thermal_node);

        // --- THERMAL DOMAIN ---
        // 1. Update Resistance based on Temp Rise
        // Note: Temp(thermal_node) is usually absolute rise or relative.
        // Let's assume the node represents "Temperature Rise above Ambient".
        Re_dynamic = Re * (1 + Alpha_Cu * temp_val);

        // 2. Heat Generation (Power In)
        // P = I^2 * R
        Pwr(thermal_node) <+ -1 * (i_coil * i_coil * Re_dynamic);

        // 3. Cooling (Leakage to Ambient)
        // Flow = (T_rise) / R_thermal
        Pwr(thermal_node) <+ temp_val / R_th;

        // 4. Thermal Mass (Storage)
        Pwr(thermal_node) <+ C_th * ddt(temp_val);

        // --- ELECTRICAL DOMAIN ---
        V(p, n) <+ i_coil * Re_dynamic; // Resistor
        V(p, n) <+ ddt(Le * i_coil);    // Inductor
        V(p, n) <+ Bl * v;              // Back EMF

        // --- MECHANICAL DOMAIN ---
        // 1. Non-linear Spring Force Calculation
        // F = Kx + K_nonlin * x^3
        spring_force = (K_si * x) + (Kms_stiff_factor * K_si * x * x * x);

        // 2. Newton's Law Summation
        // Driving Force
        F(mech_node) <+ -1 * (Bl * i_coil);

        // Reaction Forces
        F(mech_node) <+ ddt(M_si * v); // Mass
        F(mech_node) <+ R_si * v;      // Damping
        F(mech_node) <+ spring_force;  // Spring

        // --- MONITOR OUTPUT ---
        // Output position in mm for easier reading on graph
        V(x_mon) <+ x * 1000.0;
    end
endmodule
