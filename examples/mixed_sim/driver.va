`include "constants.h"
`include "discipline.h"

module driver_va(in, out);
    input in;
    output out;
    electrical in, out;

    analog begin

        V(out) <+ V(in) * 3.3;

    end

endmodule
